* kisi 0.3.3: S-parameters of the lane subcircuit in LTspice (.net), reference 50.00 ohm per port
* lane D0
* port 1 = a = D0 at U1.4 (transmitter end)
* port 2 = b = D0 at U3.2 (receiver end)
* stackup: 2 copper layers, 1.49 mm, er and tand at 1 GHz; from board file (layer by layer in the README)
*   layers (um): F.Cu 30 / 1430 er 4.42 tand 0.02 / B.Cu 30
.include "D0_ltspice.lib"

Vin a 0 AC 1 Rser=5.000000e1
XLANE a b 0 D0_lane
Rout b 0 5.000000e1
.ac lin 500 2.000000e7 1.000000e10
.net I(Rout) Vin
.options numdgt=16 reject_number_tails
.end
