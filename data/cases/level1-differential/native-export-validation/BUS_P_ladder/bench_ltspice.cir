* kisi 0.3.3: transient test bench
* lane BUS_P
* transient test bench: PRBS7 at 1.000 Gbit/s, edge 300.0 ps (10-90 %), profile lvds
* transmitter per line: R 5000 ohm, C 2.000 pF, L 0 nH; receiver per line: L 0 nH, C 2.000 pF, R 60.00 ohm
* emf scaled so that the receiver sees +-0.3500 V at DC (differential; P and N in opposite phase)
* termination R1 at U2 used as the receiver termination (60 ohm per line)
* stackup: 2 copper layers, 1.49 mm, er and tand at 1 GHz; from board file (layer by layer in the README)
*   layers (um): F.Cu 30 / 1430 er 4.42 tand 0.02 / B.Cu 30
.include "BUS_P_ltspice.lib"

* line p: transmitter
VTX_p txe_p 0 PWL(0.000000e0 -1.475833e1 6.812500e-9 -1.475833e1 7.187500e-9 1.475833e1
+ 7.812500e-9 1.475833e1 8.187500e-9 -1.475833e1 1.281250e-8 -1.475833e1 1.318750e-8 1.475833e1
+ 1.481250e-8 1.475833e1 1.518750e-8 -1.475833e1 1.881250e-8 -1.475833e1 1.918750e-8 1.475833e1
+ 1.981250e-8 1.475833e1 2.018750e-8 -1.475833e1 2.081250e-8 -1.475833e1 2.118750e-8 1.475833e1
+ 2.181250e-8 1.475833e1 2.218750e-8 -1.475833e1 2.481250e-8 -1.475833e1 2.518750e-8 1.475833e1
+ 2.881250e-8 1.475833e1 2.918750e-8 -1.475833e1 3.081250e-8 -1.475833e1 3.118750e-8 1.475833e1
+ 3.181250e-8 1.475833e1 3.218750e-8 -1.475833e1 3.481250e-8 -1.475833e1 3.518750e-8 1.475833e1
+ 3.581250e-8 1.475833e1 3.618750e-8 -1.475833e1 3.681250e-8 -1.475833e1 3.718750e-8 1.475833e1
+ 3.881250e-8 1.475833e1 3.918750e-8 -1.475833e1 4.081250e-8 -1.475833e1 4.118750e-8 1.475833e1
+ 4.381250e-8 1.475833e1 4.418750e-8 -1.475833e1 4.481250e-8 -1.475833e1 4.518750e-8 1.475833e1
+ 4.581250e-8 1.475833e1 4.618750e-8 -1.475833e1 4.681250e-8 -1.475833e1 4.718750e-8 1.475833e1
+ 4.781250e-8 1.475833e1 4.818750e-8 -1.475833e1 4.981250e-8 -1.475833e1 5.018750e-8 1.475833e1
+ 5.481250e-8 1.475833e1 5.518750e-8 -1.475833e1 5.581250e-8 -1.475833e1 5.618750e-8 1.475833e1
+ 5.681250e-8 1.475833e1 5.718750e-8 -1.475833e1 6.081250e-8 -1.475833e1 6.118750e-8 1.475833e1
+ 6.381250e-8 1.475833e1 6.418750e-8 -1.475833e1 6.681250e-8 -1.475833e1 6.718750e-8 1.475833e1
+ 6.781250e-8 1.475833e1 6.818750e-8 -1.475833e1 6.981250e-8 -1.475833e1 7.018750e-8 1.475833e1
+ 7.081250e-8 1.475833e1 7.118750e-8 -1.475833e1 7.281250e-8 -1.475833e1 7.318750e-8 1.475833e1
+ 7.481250e-8 1.475833e1 7.518750e-8 -1.475833e1 7.581250e-8 -1.475833e1 7.618750e-8 1.475833e1
+ 7.781250e-8 1.475833e1 7.818750e-8 -1.475833e1 7.881250e-8 -1.475833e1 7.918750e-8 1.475833e1
+ 7.981250e-8 1.475833e1 8.018750e-8 -1.475833e1 8.081250e-8 -1.475833e1 8.118750e-8 1.475833e1
+ 8.281250e-8 1.475833e1 8.318750e-8 -1.475833e1 8.381250e-8 -1.475833e1 8.418750e-8 1.475833e1
+ 8.781250e-8 1.475833e1 8.818750e-8 -1.475833e1 8.881250e-8 -1.475833e1 8.918750e-8 1.475833e1
+ 9.081250e-8 1.475833e1 9.118750e-8 -1.475833e1 9.381250e-8 -1.475833e1 9.418750e-8 1.475833e1
+ 9.581250e-8 1.475833e1 9.618750e-8 -1.475833e1 9.681250e-8 -1.475833e1 9.718750e-8 1.475833e1
+ 9.781250e-8 1.475833e1 9.818750e-8 -1.475833e1 9.981250e-8 -1.475833e1 1.001875e-7 1.475833e1
+ 1.008125e-7 1.475833e1 1.011875e-7 -1.475833e1 1.018125e-7 -1.475833e1 1.021875e-7 1.475833e1
+ 1.048125e-7 1.475833e1 1.051875e-7 -1.475833e1 1.058125e-7 -1.475833e1 1.061875e-7 1.475833e1
+ 1.088125e-7 1.475833e1 1.091875e-7 -1.475833e1 1.108125e-7 -1.475833e1 1.111875e-7 1.475833e1
+ 1.128125e-7 1.475833e1 1.131875e-7 -1.475833e1 1.148125e-7 -1.475833e1 1.151875e-7 1.475833e1
+ 1.158125e-7 1.475833e1 1.161875e-7 -1.475833e1 1.168125e-7 -1.475833e1 1.171875e-7 1.475833e1
+ 1.178125e-7 1.475833e1 1.181875e-7 -1.475833e1 1.188125e-7 -1.475833e1 1.191875e-7 1.475833e1
+ 1.198125e-7 1.475833e1 1.201875e-7 -1.475833e1 1.208125e-7 -1.475833e1 1.211875e-7 1.475833e1
+ 1.278125e-7 1.475833e1 1.281875e-7 -1.475833e1 1.338125e-7 -1.475833e1 1.341875e-7 1.475833e1
+ 1.348125e-7 1.475833e1 1.351875e-7 -1.475833e1 1.398125e-7 -1.475833e1 1.401875e-7 1.475833e1
+ 1.418125e-7 1.475833e1 1.421875e-7 -1.475833e1 1.458125e-7 -1.475833e1 1.461875e-7 1.475833e1
+ 1.468125e-7 1.475833e1 1.471875e-7 -1.475833e1 1.478125e-7 -1.475833e1 1.481875e-7 1.475833e1
+ 1.488125e-7 1.475833e1 1.491875e-7 -1.475833e1 1.518125e-7 -1.475833e1 1.521875e-7 1.475833e1
+ 1.558125e-7 1.475833e1 1.561875e-7 -1.475833e1 1.578125e-7 -1.475833e1 1.581875e-7 1.475833e1
+ 1.588125e-7 1.475833e1 1.591875e-7 -1.475833e1 1.618125e-7 -1.475833e1 1.621875e-7 1.475833e1
+ 1.628125e-7 1.475833e1 1.631875e-7 -1.475833e1 1.638125e-7 -1.475833e1 1.641875e-7 1.475833e1
+ 1.658125e-7 1.475833e1 1.661875e-7 -1.475833e1 1.678125e-7 -1.475833e1 1.681875e-7 1.475833e1
+ 1.708125e-7 1.475833e1 1.711875e-7 -1.475833e1 1.718125e-7 -1.475833e1 1.721875e-7 1.475833e1
+ 1.728125e-7 1.475833e1 1.731875e-7 -1.475833e1 1.738125e-7 -1.475833e1 1.741875e-7 1.475833e1
+ 1.748125e-7 1.475833e1 1.751875e-7 -1.475833e1 1.768125e-7 -1.475833e1 1.771875e-7 1.475833e1
+ 1.818125e-7 1.475833e1 1.821875e-7 -1.475833e1 1.828125e-7 -1.475833e1 1.831875e-7 1.475833e1
+ 1.838125e-7 1.475833e1 1.841875e-7 -1.475833e1 1.878125e-7 -1.475833e1 1.881875e-7 1.475833e1
+ 1.908125e-7 1.475833e1 1.911875e-7 -1.475833e1 1.938125e-7 -1.475833e1 1.941875e-7 1.475833e1
+ 1.948125e-7 1.475833e1 1.951875e-7 -1.475833e1 1.968125e-7 -1.475833e1 1.971875e-7 1.475833e1
+ 1.978125e-7 1.475833e1 1.981875e-7 -1.475833e1 1.998125e-7 -1.475833e1 2.001875e-7 1.475833e1
+ 2.018125e-7 1.475833e1 2.021875e-7 -1.475833e1 2.028125e-7 -1.475833e1 2.031875e-7 1.475833e1
+ 2.048125e-7 1.475833e1 2.051875e-7 -1.475833e1 2.058125e-7 -1.475833e1 2.061875e-7 1.475833e1
+ 2.068125e-7 1.475833e1 2.071875e-7 -1.475833e1 2.078125e-7 -1.475833e1 2.081875e-7 1.475833e1
+ 2.098125e-7 1.475833e1 2.101875e-7 -1.475833e1 2.108125e-7 -1.475833e1 2.111875e-7 1.475833e1
+ 2.148125e-7 1.475833e1 2.151875e-7 -1.475833e1 2.158125e-7 -1.475833e1 2.161875e-7 1.475833e1
+ 2.178125e-7 1.475833e1 2.181875e-7 -1.475833e1 2.208125e-7 -1.475833e1 2.211875e-7 1.475833e1
+ 2.228125e-7 1.475833e1 2.231875e-7 -1.475833e1 2.238125e-7 -1.475833e1 2.241875e-7 1.475833e1
+ 2.248125e-7 1.475833e1 2.251875e-7 -1.475833e1 2.268125e-7 -1.475833e1 2.271875e-7 1.475833e1
+ 2.278125e-7 1.475833e1 2.281875e-7 -1.475833e1 2.288125e-7 -1.475833e1 2.291875e-7 1.475833e1
+ 2.318125e-7 1.475833e1 2.321875e-7 -1.475833e1 2.328125e-7 -1.475833e1 2.331875e-7 1.475833e1
+ 2.358125e-7 1.475833e1 2.361875e-7 -1.475833e1 2.378125e-7 -1.475833e1 2.381875e-7 1.475833e1
+ 2.398125e-7 1.475833e1 2.401875e-7 -1.475833e1 2.418125e-7 -1.475833e1 2.421875e-7 1.475833e1
+ 2.428125e-7 1.475833e1 2.431875e-7 -1.475833e1 2.438125e-7 -1.475833e1 2.441875e-7 1.475833e1
+ 2.448125e-7 1.475833e1 2.451875e-7 -1.475833e1 2.458125e-7 -1.475833e1 2.461875e-7 1.475833e1
+ 2.468125e-7 1.475833e1 2.471875e-7 -1.475833e1 2.478125e-7 -1.475833e1 2.481875e-7 1.475833e1)
RTX_p txe_p txd_p 5.000000e3
CTX_p txd_p 0 2.000000e-12
VTXL_p txd_p ap 0
* line p: receiver
VRXL_p bp rxd_p 0
CRX_p rxd_p 0 2.000000e-12
RRX_p rxd_p 0 6.000000e1
* line n: transmitter
VTX_n txe_n 0 PWL(0.000000e0 1.475833e1 6.812500e-9 1.475833e1 7.187500e-9 -1.475833e1
+ 7.812500e-9 -1.475833e1 8.187500e-9 1.475833e1 1.281250e-8 1.475833e1 1.318750e-8 -1.475833e1
+ 1.481250e-8 -1.475833e1 1.518750e-8 1.475833e1 1.881250e-8 1.475833e1 1.918750e-8 -1.475833e1
+ 1.981250e-8 -1.475833e1 2.018750e-8 1.475833e1 2.081250e-8 1.475833e1 2.118750e-8 -1.475833e1
+ 2.181250e-8 -1.475833e1 2.218750e-8 1.475833e1 2.481250e-8 1.475833e1 2.518750e-8 -1.475833e1
+ 2.881250e-8 -1.475833e1 2.918750e-8 1.475833e1 3.081250e-8 1.475833e1 3.118750e-8 -1.475833e1
+ 3.181250e-8 -1.475833e1 3.218750e-8 1.475833e1 3.481250e-8 1.475833e1 3.518750e-8 -1.475833e1
+ 3.581250e-8 -1.475833e1 3.618750e-8 1.475833e1 3.681250e-8 1.475833e1 3.718750e-8 -1.475833e1
+ 3.881250e-8 -1.475833e1 3.918750e-8 1.475833e1 4.081250e-8 1.475833e1 4.118750e-8 -1.475833e1
+ 4.381250e-8 -1.475833e1 4.418750e-8 1.475833e1 4.481250e-8 1.475833e1 4.518750e-8 -1.475833e1
+ 4.581250e-8 -1.475833e1 4.618750e-8 1.475833e1 4.681250e-8 1.475833e1 4.718750e-8 -1.475833e1
+ 4.781250e-8 -1.475833e1 4.818750e-8 1.475833e1 4.981250e-8 1.475833e1 5.018750e-8 -1.475833e1
+ 5.481250e-8 -1.475833e1 5.518750e-8 1.475833e1 5.581250e-8 1.475833e1 5.618750e-8 -1.475833e1
+ 5.681250e-8 -1.475833e1 5.718750e-8 1.475833e1 6.081250e-8 1.475833e1 6.118750e-8 -1.475833e1
+ 6.381250e-8 -1.475833e1 6.418750e-8 1.475833e1 6.681250e-8 1.475833e1 6.718750e-8 -1.475833e1
+ 6.781250e-8 -1.475833e1 6.818750e-8 1.475833e1 6.981250e-8 1.475833e1 7.018750e-8 -1.475833e1
+ 7.081250e-8 -1.475833e1 7.118750e-8 1.475833e1 7.281250e-8 1.475833e1 7.318750e-8 -1.475833e1
+ 7.481250e-8 -1.475833e1 7.518750e-8 1.475833e1 7.581250e-8 1.475833e1 7.618750e-8 -1.475833e1
+ 7.781250e-8 -1.475833e1 7.818750e-8 1.475833e1 7.881250e-8 1.475833e1 7.918750e-8 -1.475833e1
+ 7.981250e-8 -1.475833e1 8.018750e-8 1.475833e1 8.081250e-8 1.475833e1 8.118750e-8 -1.475833e1
+ 8.281250e-8 -1.475833e1 8.318750e-8 1.475833e1 8.381250e-8 1.475833e1 8.418750e-8 -1.475833e1
+ 8.781250e-8 -1.475833e1 8.818750e-8 1.475833e1 8.881250e-8 1.475833e1 8.918750e-8 -1.475833e1
+ 9.081250e-8 -1.475833e1 9.118750e-8 1.475833e1 9.381250e-8 1.475833e1 9.418750e-8 -1.475833e1
+ 9.581250e-8 -1.475833e1 9.618750e-8 1.475833e1 9.681250e-8 1.475833e1 9.718750e-8 -1.475833e1
+ 9.781250e-8 -1.475833e1 9.818750e-8 1.475833e1 9.981250e-8 1.475833e1 1.001875e-7 -1.475833e1
+ 1.008125e-7 -1.475833e1 1.011875e-7 1.475833e1 1.018125e-7 1.475833e1 1.021875e-7 -1.475833e1
+ 1.048125e-7 -1.475833e1 1.051875e-7 1.475833e1 1.058125e-7 1.475833e1 1.061875e-7 -1.475833e1
+ 1.088125e-7 -1.475833e1 1.091875e-7 1.475833e1 1.108125e-7 1.475833e1 1.111875e-7 -1.475833e1
+ 1.128125e-7 -1.475833e1 1.131875e-7 1.475833e1 1.148125e-7 1.475833e1 1.151875e-7 -1.475833e1
+ 1.158125e-7 -1.475833e1 1.161875e-7 1.475833e1 1.168125e-7 1.475833e1 1.171875e-7 -1.475833e1
+ 1.178125e-7 -1.475833e1 1.181875e-7 1.475833e1 1.188125e-7 1.475833e1 1.191875e-7 -1.475833e1
+ 1.198125e-7 -1.475833e1 1.201875e-7 1.475833e1 1.208125e-7 1.475833e1 1.211875e-7 -1.475833e1
+ 1.278125e-7 -1.475833e1 1.281875e-7 1.475833e1 1.338125e-7 1.475833e1 1.341875e-7 -1.475833e1
+ 1.348125e-7 -1.475833e1 1.351875e-7 1.475833e1 1.398125e-7 1.475833e1 1.401875e-7 -1.475833e1
+ 1.418125e-7 -1.475833e1 1.421875e-7 1.475833e1 1.458125e-7 1.475833e1 1.461875e-7 -1.475833e1
+ 1.468125e-7 -1.475833e1 1.471875e-7 1.475833e1 1.478125e-7 1.475833e1 1.481875e-7 -1.475833e1
+ 1.488125e-7 -1.475833e1 1.491875e-7 1.475833e1 1.518125e-7 1.475833e1 1.521875e-7 -1.475833e1
+ 1.558125e-7 -1.475833e1 1.561875e-7 1.475833e1 1.578125e-7 1.475833e1 1.581875e-7 -1.475833e1
+ 1.588125e-7 -1.475833e1 1.591875e-7 1.475833e1 1.618125e-7 1.475833e1 1.621875e-7 -1.475833e1
+ 1.628125e-7 -1.475833e1 1.631875e-7 1.475833e1 1.638125e-7 1.475833e1 1.641875e-7 -1.475833e1
+ 1.658125e-7 -1.475833e1 1.661875e-7 1.475833e1 1.678125e-7 1.475833e1 1.681875e-7 -1.475833e1
+ 1.708125e-7 -1.475833e1 1.711875e-7 1.475833e1 1.718125e-7 1.475833e1 1.721875e-7 -1.475833e1
+ 1.728125e-7 -1.475833e1 1.731875e-7 1.475833e1 1.738125e-7 1.475833e1 1.741875e-7 -1.475833e1
+ 1.748125e-7 -1.475833e1 1.751875e-7 1.475833e1 1.768125e-7 1.475833e1 1.771875e-7 -1.475833e1
+ 1.818125e-7 -1.475833e1 1.821875e-7 1.475833e1 1.828125e-7 1.475833e1 1.831875e-7 -1.475833e1
+ 1.838125e-7 -1.475833e1 1.841875e-7 1.475833e1 1.878125e-7 1.475833e1 1.881875e-7 -1.475833e1
+ 1.908125e-7 -1.475833e1 1.911875e-7 1.475833e1 1.938125e-7 1.475833e1 1.941875e-7 -1.475833e1
+ 1.948125e-7 -1.475833e1 1.951875e-7 1.475833e1 1.968125e-7 1.475833e1 1.971875e-7 -1.475833e1
+ 1.978125e-7 -1.475833e1 1.981875e-7 1.475833e1 1.998125e-7 1.475833e1 2.001875e-7 -1.475833e1
+ 2.018125e-7 -1.475833e1 2.021875e-7 1.475833e1 2.028125e-7 1.475833e1 2.031875e-7 -1.475833e1
+ 2.048125e-7 -1.475833e1 2.051875e-7 1.475833e1 2.058125e-7 1.475833e1 2.061875e-7 -1.475833e1
+ 2.068125e-7 -1.475833e1 2.071875e-7 1.475833e1 2.078125e-7 1.475833e1 2.081875e-7 -1.475833e1
+ 2.098125e-7 -1.475833e1 2.101875e-7 1.475833e1 2.108125e-7 1.475833e1 2.111875e-7 -1.475833e1
+ 2.148125e-7 -1.475833e1 2.151875e-7 1.475833e1 2.158125e-7 1.475833e1 2.161875e-7 -1.475833e1
+ 2.178125e-7 -1.475833e1 2.181875e-7 1.475833e1 2.208125e-7 1.475833e1 2.211875e-7 -1.475833e1
+ 2.228125e-7 -1.475833e1 2.231875e-7 1.475833e1 2.238125e-7 1.475833e1 2.241875e-7 -1.475833e1
+ 2.248125e-7 -1.475833e1 2.251875e-7 1.475833e1 2.268125e-7 1.475833e1 2.271875e-7 -1.475833e1
+ 2.278125e-7 -1.475833e1 2.281875e-7 1.475833e1 2.288125e-7 1.475833e1 2.291875e-7 -1.475833e1
+ 2.318125e-7 -1.475833e1 2.321875e-7 1.475833e1 2.328125e-7 1.475833e1 2.331875e-7 -1.475833e1
+ 2.358125e-7 -1.475833e1 2.361875e-7 1.475833e1 2.378125e-7 1.475833e1 2.381875e-7 -1.475833e1
+ 2.398125e-7 -1.475833e1 2.401875e-7 1.475833e1 2.418125e-7 1.475833e1 2.421875e-7 -1.475833e1
+ 2.428125e-7 -1.475833e1 2.431875e-7 1.475833e1 2.438125e-7 1.475833e1 2.441875e-7 -1.475833e1
+ 2.448125e-7 -1.475833e1 2.451875e-7 1.475833e1 2.458125e-7 1.475833e1 2.461875e-7 -1.475833e1
+ 2.468125e-7 -1.475833e1 2.471875e-7 1.475833e1 2.478125e-7 1.475833e1 2.481875e-7 -1.475833e1)
RTX_n txe_n txd_n 5.000000e3
CTX_n txd_n 0 2.000000e-12
VTXL_n txd_n an 0
* line n: receiver
VRXL_n bn rxd_n 0
CRX_n rxd_n 0 2.000000e-12
RRX_n rxd_n 0 6.000000e1

XLANE ap an bp bn 0 BUS_P_lane

Bvrx vrx 0 V=V(rxd_p)-V(rxd_n)
.tran 3.000000e-11 2.566306e-7 0 3.000000e-11
.save V(vrx)
.options plotwinsize=0 numdgt=16 reject_number_tails
* measurements (in the .log file): the first rising zero crossing, the received voltage at bit centres of the
* second pattern period and its extremes there
.meas TRAN t50 WHEN V(vrx)=0 RISE=1
.meas TRAN v_bit130 FIND V(vrx) AT=1.318153e-7
.meas TRAN v_bit146 FIND V(vrx) AT=1.478153e-7
.meas TRAN v_bit162 FIND V(vrx) AT=1.638153e-7
.meas TRAN v_bit178 FIND V(vrx) AT=1.798153e-7
.meas TRAN v_bit194 FIND V(vrx) AT=1.958153e-7
.meas TRAN v_bit210 FIND V(vrx) AT=2.118153e-7
.meas TRAN v_bit226 FIND V(vrx) AT=2.278153e-7
.meas TRAN v_bit242 FIND V(vrx) AT=2.438153e-7
.meas TRAN vmax MAX V(vrx) FROM=1.283153e-7 TO=2.553153e-7
.meas TRAN vmin MIN V(vrx) FROM=1.283153e-7 TO=2.553153e-7
.end
