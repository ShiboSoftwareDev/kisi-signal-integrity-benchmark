* kisi 0.3.3: S-parameters of the lane subcircuit, reference 50.00 ohm per port
* lane BUS_P
* port 1 = ap = P BUS_P at U1.6 (transmitter end)
* port 2 = an = N BUS_N at U1.7 (transmitter end)
* port 3 = bp = P BUS_P at U2.6 (receiver end)
* port 4 = bn = N BUS_N at U2.7 (receiver end)
* stackup: 2 copper layers, 1.49 mm, er and tand at 1 GHz; from board file (layer by layer in the README)
*   layers (um): F.Cu 30 / 1430 er 4.42 tand 0.02 / B.Cu 30
.include "BUS_P.lib"

P1 ap 0 port=1 z0=5.000000e1
P2 an 0 port=2 z0=5.000000e1
P3 bp 0 port=3 z0=5.000000e1
P4 bn 0 port=4 z0=5.000000e1
XLANE ap an bp bn 0 BUS_P_lane

.ac lin 500 2.000000e7 1.000000e10
.lin sparcalc=1 format=touchstone2 dataformat=ri file=sparam_xyce.s4p
.end
