* kisi 0.3.3: transient test bench
* lane DATA
* transient test bench: PRBS7 at 1.000 Gbit/s, edge 100.0 ps (10-90 %), profile se50
* transmitter per line: R 50.00 ohm, C 1.000 pF, L 0 nH; receiver per line: L 0 nH, C 1.000 pF, R 50.00 ohm
* emf scaled so that the receiver sees +-1.000 V at DC
* stackup: 2 copper layers, 1.49 mm, er and tand at 1 GHz; from board file (layer by layer in the README)
*   layers (um): F.Cu 30 / 1430 er 4.42 tand 0.02 / B.Cu 30
.include "DATA.lib"

* line p: transmitter
VTX_p txe_p 0 PWL(0.000000e0 -2.000000e0 6.937500e-9 -2.000000e0 7.062500e-9 2.000000e0
+ 7.937500e-9 2.000000e0 8.062500e-9 -2.000000e0 1.293750e-8 -2.000000e0 1.306250e-8 2.000000e0
+ 1.493750e-8 2.000000e0 1.506250e-8 -2.000000e0 1.893750e-8 -2.000000e0 1.906250e-8 2.000000e0
+ 1.993750e-8 2.000000e0 2.006250e-8 -2.000000e0 2.093750e-8 -2.000000e0 2.106250e-8 2.000000e0
+ 2.193750e-8 2.000000e0 2.206250e-8 -2.000000e0 2.493750e-8 -2.000000e0 2.506250e-8 2.000000e0
+ 2.893750e-8 2.000000e0 2.906250e-8 -2.000000e0 3.093750e-8 -2.000000e0 3.106250e-8 2.000000e0
+ 3.193750e-8 2.000000e0 3.206250e-8 -2.000000e0 3.493750e-8 -2.000000e0 3.506250e-8 2.000000e0
+ 3.593750e-8 2.000000e0 3.606250e-8 -2.000000e0 3.693750e-8 -2.000000e0 3.706250e-8 2.000000e0
+ 3.893750e-8 2.000000e0 3.906250e-8 -2.000000e0 4.093750e-8 -2.000000e0 4.106250e-8 2.000000e0
+ 4.393750e-8 2.000000e0 4.406250e-8 -2.000000e0 4.493750e-8 -2.000000e0 4.506250e-8 2.000000e0
+ 4.593750e-8 2.000000e0 4.606250e-8 -2.000000e0 4.693750e-8 -2.000000e0 4.706250e-8 2.000000e0
+ 4.793750e-8 2.000000e0 4.806250e-8 -2.000000e0 4.993750e-8 -2.000000e0 5.006250e-8 2.000000e0
+ 5.493750e-8 2.000000e0 5.506250e-8 -2.000000e0 5.593750e-8 -2.000000e0 5.606250e-8 2.000000e0
+ 5.693750e-8 2.000000e0 5.706250e-8 -2.000000e0 6.093750e-8 -2.000000e0 6.106250e-8 2.000000e0
+ 6.393750e-8 2.000000e0 6.406250e-8 -2.000000e0 6.693750e-8 -2.000000e0 6.706250e-8 2.000000e0
+ 6.793750e-8 2.000000e0 6.806250e-8 -2.000000e0 6.993750e-8 -2.000000e0 7.006250e-8 2.000000e0
+ 7.093750e-8 2.000000e0 7.106250e-8 -2.000000e0 7.293750e-8 -2.000000e0 7.306250e-8 2.000000e0
+ 7.493750e-8 2.000000e0 7.506250e-8 -2.000000e0 7.593750e-8 -2.000000e0 7.606250e-8 2.000000e0
+ 7.793750e-8 2.000000e0 7.806250e-8 -2.000000e0 7.893750e-8 -2.000000e0 7.906250e-8 2.000000e0
+ 7.993750e-8 2.000000e0 8.006250e-8 -2.000000e0 8.093750e-8 -2.000000e0 8.106250e-8 2.000000e0
+ 8.293750e-8 2.000000e0 8.306250e-8 -2.000000e0 8.393750e-8 -2.000000e0 8.406250e-8 2.000000e0
+ 8.793750e-8 2.000000e0 8.806250e-8 -2.000000e0 8.893750e-8 -2.000000e0 8.906250e-8 2.000000e0
+ 9.093750e-8 2.000000e0 9.106250e-8 -2.000000e0 9.393750e-8 -2.000000e0 9.406250e-8 2.000000e0
+ 9.593750e-8 2.000000e0 9.606250e-8 -2.000000e0 9.693750e-8 -2.000000e0 9.706250e-8 2.000000e0
+ 9.793750e-8 2.000000e0 9.806250e-8 -2.000000e0 9.993750e-8 -2.000000e0 1.000625e-7 2.000000e0
+ 1.009375e-7 2.000000e0 1.010625e-7 -2.000000e0 1.019375e-7 -2.000000e0 1.020625e-7 2.000000e0
+ 1.049375e-7 2.000000e0 1.050625e-7 -2.000000e0 1.059375e-7 -2.000000e0 1.060625e-7 2.000000e0
+ 1.089375e-7 2.000000e0 1.090625e-7 -2.000000e0 1.109375e-7 -2.000000e0 1.110625e-7 2.000000e0
+ 1.129375e-7 2.000000e0 1.130625e-7 -2.000000e0 1.149375e-7 -2.000000e0 1.150625e-7 2.000000e0
+ 1.159375e-7 2.000000e0 1.160625e-7 -2.000000e0 1.169375e-7 -2.000000e0 1.170625e-7 2.000000e0
+ 1.179375e-7 2.000000e0 1.180625e-7 -2.000000e0 1.189375e-7 -2.000000e0 1.190625e-7 2.000000e0
+ 1.199375e-7 2.000000e0 1.200625e-7 -2.000000e0 1.209375e-7 -2.000000e0 1.210625e-7 2.000000e0
+ 1.279375e-7 2.000000e0 1.280625e-7 -2.000000e0 1.339375e-7 -2.000000e0 1.340625e-7 2.000000e0
+ 1.349375e-7 2.000000e0 1.350625e-7 -2.000000e0 1.399375e-7 -2.000000e0 1.400625e-7 2.000000e0
+ 1.419375e-7 2.000000e0 1.420625e-7 -2.000000e0 1.459375e-7 -2.000000e0 1.460625e-7 2.000000e0
+ 1.469375e-7 2.000000e0 1.470625e-7 -2.000000e0 1.479375e-7 -2.000000e0 1.480625e-7 2.000000e0
+ 1.489375e-7 2.000000e0 1.490625e-7 -2.000000e0 1.519375e-7 -2.000000e0 1.520625e-7 2.000000e0
+ 1.559375e-7 2.000000e0 1.560625e-7 -2.000000e0 1.579375e-7 -2.000000e0 1.580625e-7 2.000000e0
+ 1.589375e-7 2.000000e0 1.590625e-7 -2.000000e0 1.619375e-7 -2.000000e0 1.620625e-7 2.000000e0
+ 1.629375e-7 2.000000e0 1.630625e-7 -2.000000e0 1.639375e-7 -2.000000e0 1.640625e-7 2.000000e0
+ 1.659375e-7 2.000000e0 1.660625e-7 -2.000000e0 1.679375e-7 -2.000000e0 1.680625e-7 2.000000e0
+ 1.709375e-7 2.000000e0 1.710625e-7 -2.000000e0 1.719375e-7 -2.000000e0 1.720625e-7 2.000000e0
+ 1.729375e-7 2.000000e0 1.730625e-7 -2.000000e0 1.739375e-7 -2.000000e0 1.740625e-7 2.000000e0
+ 1.749375e-7 2.000000e0 1.750625e-7 -2.000000e0 1.769375e-7 -2.000000e0 1.770625e-7 2.000000e0
+ 1.819375e-7 2.000000e0 1.820625e-7 -2.000000e0 1.829375e-7 -2.000000e0 1.830625e-7 2.000000e0
+ 1.839375e-7 2.000000e0 1.840625e-7 -2.000000e0 1.879375e-7 -2.000000e0 1.880625e-7 2.000000e0
+ 1.909375e-7 2.000000e0 1.910625e-7 -2.000000e0 1.939375e-7 -2.000000e0 1.940625e-7 2.000000e0
+ 1.949375e-7 2.000000e0 1.950625e-7 -2.000000e0 1.969375e-7 -2.000000e0 1.970625e-7 2.000000e0
+ 1.979375e-7 2.000000e0 1.980625e-7 -2.000000e0 1.999375e-7 -2.000000e0 2.000625e-7 2.000000e0
+ 2.019375e-7 2.000000e0 2.020625e-7 -2.000000e0 2.029375e-7 -2.000000e0 2.030625e-7 2.000000e0
+ 2.049375e-7 2.000000e0 2.050625e-7 -2.000000e0 2.059375e-7 -2.000000e0 2.060625e-7 2.000000e0
+ 2.069375e-7 2.000000e0 2.070625e-7 -2.000000e0 2.079375e-7 -2.000000e0 2.080625e-7 2.000000e0
+ 2.099375e-7 2.000000e0 2.100625e-7 -2.000000e0 2.109375e-7 -2.000000e0 2.110625e-7 2.000000e0
+ 2.149375e-7 2.000000e0 2.150625e-7 -2.000000e0 2.159375e-7 -2.000000e0 2.160625e-7 2.000000e0
+ 2.179375e-7 2.000000e0 2.180625e-7 -2.000000e0 2.209375e-7 -2.000000e0 2.210625e-7 2.000000e0
+ 2.229375e-7 2.000000e0 2.230625e-7 -2.000000e0 2.239375e-7 -2.000000e0 2.240625e-7 2.000000e0
+ 2.249375e-7 2.000000e0 2.250625e-7 -2.000000e0 2.269375e-7 -2.000000e0 2.270625e-7 2.000000e0
+ 2.279375e-7 2.000000e0 2.280625e-7 -2.000000e0 2.289375e-7 -2.000000e0 2.290625e-7 2.000000e0
+ 2.319375e-7 2.000000e0 2.320625e-7 -2.000000e0 2.329375e-7 -2.000000e0 2.330625e-7 2.000000e0
+ 2.359375e-7 2.000000e0 2.360625e-7 -2.000000e0 2.379375e-7 -2.000000e0 2.380625e-7 2.000000e0
+ 2.399375e-7 2.000000e0 2.400625e-7 -2.000000e0 2.419375e-7 -2.000000e0 2.420625e-7 2.000000e0
+ 2.429375e-7 2.000000e0 2.430625e-7 -2.000000e0 2.439375e-7 -2.000000e0 2.440625e-7 2.000000e0
+ 2.449375e-7 2.000000e0 2.450625e-7 -2.000000e0 2.459375e-7 -2.000000e0 2.460625e-7 2.000000e0
+ 2.469375e-7 2.000000e0 2.470625e-7 -2.000000e0 2.479375e-7 -2.000000e0 2.480625e-7 2.000000e0)
RTX_p txe_p txd_p 5.000000e1
CTX_p txd_p 0 1.000000e-12
VTXL_p txd_p a 0
* line p: receiver
VRXL_p b rxd_p 0
CRX_p rxd_p 0 1.000000e-12
RRX_p rxd_p 0 5.000000e1

XLANE a b 0 DATA_lane

.tran 1.000000e-11 2.563242e-7
.control
run
wrdata bench_ngspice.txt v(rxd_p)
.endc
.end
